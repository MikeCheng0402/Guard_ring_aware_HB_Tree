.subckt m1 AVSS VDD_REG vout vo nodeEnd
MM1 VDD_REG vo vout AVSS nch_ulvt_mac fin=10 l=0.09u m=5 roll=1 common=0
.ends

.subckt m1 AVSS VDD_REG vout vo nodeEnd
MM5 VDD_REG vo vout AVSS nch_ulvt_mac fin=10 l=0.09u m=5 roll=1 common=0
.ends

.subckt m1 AVSS VDD_REG vout vo nodeEnd
MM3 VDD_REG vo vout AVSS nch_ulvt_mac fin=20 l=0.09u m=6 roll=1 common=0
.ends

.subckt m1 AVSS VDD_REG vout vo nodeEnd
MM7 VDD_REG vo vout AVSS nch_ulvt_mac fin=20 l=0.09u m=6 roll=1 common=0
.ends

.subckt m1 AVSS VDD_REG vout vo nodeEnd
MM9 VDD_REG vo vout AVSS nch_ulvt_mac fin=80 l=0.09u m=2 roll=1 common=0
.ends

.subckt m1 AVSS VDD_REG vout vo nodeEnd
MM2 VDD_REG vo vout AVSS nch_ulvt_mac fin=10 l=0.09u m=8 roll=1 common=0
.ends

.subckt m1 AVSS VDD_REG vout vo nodeEnd
MM6 VDD_REG vo vout AVSS nch_ulvt_mac fin=10 l=0.09u m=8 roll=1 common=0
.ends

.subckt m1 AVSS VDD_REG vout vo nodeEnd
MM4 VDD_REG vo vout AVSS nch_ulvt_mac fin=20 l=0.09u m=3 roll=1 common=0
.ends

.subckt m1 AVSS VDD_REG vout vo nodeEnd
MM8 VDD_REG vo vout AVSS nch_ulvt_mac fin=20 l=0.09u m=3 roll=1 common=0
.ends

.subckt m1 AVSS VDD_REG vout vo nodeEnd
MM10 VDD_REG vo vout AVSS nch_ulvt_mac fin=10 l=0.09u m=1 roll=1 common=0
.ends

.subckt m1 AVSS VDD_REG vout vo nodeEnd
MM11 VDD_REG vo vout AVSS nch_ulvt_mac fin=3 l=0.09u m=1 roll=1 common=0
.ends

.subckt m1 AVSS VDD_REG vout vo nodeEnd
MM12 VDD_REG vo vout AVSS nch_ulvt_mac fin=3 l=0.09u m=1 roll=1 common=0
.ends

.subckt m1 AVSS VDD_REG vout vo nodeEnd
MM13 VDD_REG vo vout AVSS nch_ulvt_mac fin=3 l=0.09u m=1 roll=1 common=0
.ends

.subckt m1 AVSS VDD_REG vout vo nodeEnd
MM14 VDD_REG vo vout AVSS nch_ulvt_mac fin=3 l=0.09u m=1 roll=1 common=0
.ends

.subckt m1 AVSS VDD_REG vout vo nodeEnd
MM15 VDD_REG vo vout AVSS nch_ulvt_mac fin=3 l=0.09u m=1 roll=1 common=0
.ends

.subckt m1 AVSS VDD_REG vout vo nodeEnd
MM16 VDD_REG vo vout AVSS nch_ulvt_mac fin=3 l=0.09u m=1 roll=1 common=0
.ends

.subckt m1 AVSS VDD_REG vout vo nodeEnd
MM17 VDD_REG vo vout AVSS nch_ulvt_mac fin=3 l=0.09u m=1 roll=1 common=0
.ends

.subckt m1 AVSS VDD_REG vout vo nodeEnd
MM18 VDD_REG vo vout AVSS nch_ulvt_mac fin=3 l=0.09u m=1 roll=1 common=0
.ends
.end
